/*
################################################################################
#                                                                              #
#  Developer: Wilson Chen                                                      #
#  Start Date: 2022/11/11                                                      #
#  Reference: locker, utility_program, footprint_utility_program               #
#  Purpose:                                                                    #
#       To check LOGO symbols                                                  #
#                                                                              #
################################################################################
*/

;;;;;;;;;;;;;;;;;;;;;;;;;;;;;;;;;;;;;;;;;;;;;;;;;; Global Variable

procedure( Init_checklogo()
	setq( _allegro_unit car( axlDBGetDesignUnits()))

	InitCheckBaseData_footprintutilityprogram( t)
	setq( _check_logo_logname "")
)

;;;;;;;;;;;;;;;;;;;;;;;;;;;;;;;;;;;;;;;;;;;;;;;;;; End of Global Variable

;;;;;;;;;;;;;;;;;;;;;;;;;;;;;;;;;;;;;;;;;;;;;;;;;; Main

procedure( Main_checklogo()
	prog( ( log_info out_port)
		Init_checklogo()

		unless( Main_footprintlocker()
			return( nil)
		)

		log_info = SetUpLog_utilityprogram( "check_logo_symbol")
		unless( log_info
			return( nil)
		)

		out_port = nth( 0 log_info)
		_check_logo_logname = nth( 1 log_info)

		fprintf( out_port "Board file name: %s\n" axlCurrentDesign())
		fprintf( out_port "Date-time: %L\n" getCurrentTime())
		fprintf( out_port "\n\n")

		fprintf( out_port "Introduction: To check LOGO symbols are created according to SOP\n")
		fprintf( out_port "\n\n")
		fprintf( out_port "DFA_DEV_CLASS: %s\n" GetDfaDevClass_footprintutilityprogram())
		fprintf( out_port "\n\n")

		fprintf( out_port "Manual check: ")
		fprintf( out_port "1. SILKSCREEN_TOP logo size\n")
		fprintf( out_port "\n\n")
		fprintf( out_port GetLogSeperator_utilityprogram())
		fprintf( out_port "\n\n")

		Check_checklogo( out_port)

		close( out_port)
		axlUIViewFileCreate( _check_logo_logname "Check LOGO report" nil)
	)
)

;;;;;;;;;;;;;;;;;;;;;;;;;;;;;;;;;;;;;;;;;;;;;;;;;; End of Main

;;;;;;;;;;;;;;;;;;;;;;;;;;;;;;;;;;;;;;;;;;;;;;;;;; Function

procedure( Check_checklogo( out_port)
	let( ( visible_ls)
		visible_ls = axlVisibleGet()
		fprintf( out_port "1.")
		CheckSilkscreenTop_checklogo( out_port)
		fprintf( out_port "2.")
		CheckNote_footprintutilityprogram( out_port)
		axlVisibleSet( visible_ls)
	)
)

procedure( CheckSilkscreenTop_checklogo( out_port)
	let( ( result layer line_ls shape_ls)
		result = t
		layer = _layer_pkg_skt
		fprintf( out_port "Check line or shape on %s\n" layer)
		line_ls = GetLineList_utilityprogram( layer)
		shape_ls = GetShapeList_utilityprogram( layer)
		unless( remq( nil append( line_ls shape_ls))
			fprintf( out_port "\tNo line or shape found on %s\n" layer)
			result = nil
		)

		PrintCheckResult_footprintutilityprogram( result layer out_port)
	)
)

;;;;;;;;;;;;;;;;;;;;;;;;;;;;;;;;;;;;;;;;;;;;;;;;;; End of Function

;;;;;;;;;;;;;;;;;;;;;;;;;;;;;;;;;;;;;;;;;;;;;;;;;; Setup

axlCmdRegister( "check_logo" 'Main_checklogo)
/*
(encrypt "c:/skill/check_logo_v1d1.il" "c:/skill/check_logo_v1d1.ile")
(load "check_logo_v1d1.il")
(load "check_logo_v1d1.ile")
*/
;;;;;;;;;;;;;;;;;;;;;;;;;;;;;;;;;;;;;;;;;;;;;;;;;; End of Setup
